RC Low Pass Filter AC
Vs in 0 AC 1
R1 in out 1k
C1 out 0 100n
.AC DEC 100 10 10MEG
.END
