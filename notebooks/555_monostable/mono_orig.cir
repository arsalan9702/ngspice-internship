555 Monostable Mode
.include 555.cir

Vcc vcc 0 DC $VCC

* Control voltage bypass
Cc con 0 10n

* Trigger pulse
Vtrig trig 0 PULSE($VCC 0 $TDELAY 1u 1u $TRIGPULSE $TEND)

* Timing network
Rt vcc timing $RT
Ct timing 0 $CT IC=0

*                gnd trig out rst con thr    dis    vcc
X1              0   trig out vcc con timing timing vcc 555

.SAVE v(out) v(timing) v(trig)

.TRAN $TSTEP $TEND UIC
.END
