* 555 Timer behavioral model -- 555.cir
*
* Version 2 using generic OpAmp model from the forum.
*    Now supports output voltage set by Vcc Pin.
*    This is mostly a timing model and may not be DC
*    accurate in all cases.
*
*           Ground
*           | Trigger
*           | | Output
*           | | | Reset
*           | | | | Control
*           | | | | | Threshold
*           | | | | | | Discharge
*           | | | | | | | Vcc
*           | | | | | | | |
.subckt 555 1 2 3 4 5 6 7 8

R1  8  5 5000
R2  5 10 5000
R3 10  1 5000

X1  6 5 8 0 11  genopa1    ; the reset comparitor
X2 10 2 8 0 12  genopa1    ; the set comparitor

*        R  S    R  S
abridge [11 12] [22 21] adc_buff ; bridge from comparitors to set reset controls

a0 z1 pulldown1            ; pull-down for unused clock and data

*  data  clock set reset q   qbar
a1  z1    z1   21   25   23   24  flop1  ; the flip flop

abridge1 [24] [13] dac1    ; bridge qbar to discharge timing cap, turn on Q1
abridge2 [24] [26] dac1    ; bridge qbar  to pseudo tristate driver

Q1 7  13 1 N               ; the discharge transistor

* Here is the active low master reset function from pin 4.

abridge3 [4] [30] adc_buff ; bridge pin 4 to the digital domain

a2 30 31 inv1

a3 [22 31] 25 or1          ; Reset when the external resit is assered or the comparitor trips.
*
* Make the Q output of the flip-flop drive to Vcc when driven
*
R4 3 8 100
Q2 3 26 0 N

* Models
.model adc_buff adc_bridge(in_low = 0.7 in_high = 3.0)  ; 0.7 V threshold per NE555 data sheet

.model flop1 d_dff(clk_delay = 13.0e-9 set_delay = 25.0e-9
+ reset_delay = 27.0e-9 ic = 0 rise_delay = 10.0e-9
+ fall_delay = 3e-9)

.model pulldown1 d_pulldown(load = 20.0e-12)

.model dac1 dac_bridge(out_low = 0.1 out_high = 1.0 out_undef = 2.2
+ input_load = 5.0e-12 t_rise = 50e-9
+ t_fall = 20e-9)

.model N NPN

.model inv1 d_inverter(rise_delay = 0.5e-9 fall_delay = 0.3e-9
+ input_load = 0.5e-12)

.model or1 d_or(rise_delay = 0.5e-9 fall_delay = 0.3e-9
+ input_load = 0.5e-12)

.ends

* generic OpAmp model
* gain, phase, offset, limits to power supply, input and output resistance

.subckt genopa1 in+ in- vcc vee out params: POLE=20 GAIN=20k VOFFSET=5m ROUT=10 RIN=10Meg

Rin   in+ in+ {RIN}
Voff  in+ inoff dc {VOFFSET}
G10   0 int inoff in- 100u
R1    int 0 {GAIN/100u}
C1    int 0 {1/(6.28*(GAIN/100u)*POLE)}
Eout  2 0 int 0 1
Rout  2 out {ROUT}
Elow  3 0 vee 0 1
Ehigh 8 0 vcc 0 1
Dlow  3   int Dlimit
Dhigh int 8   Dlimit

.model Dlimit D N=0.01
.ends

.end
