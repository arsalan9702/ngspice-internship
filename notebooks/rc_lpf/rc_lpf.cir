RC Low Pass Filter
Vin in 0 AC 1
R1 in out 1k
C1 out 0 1u

.AC DEC 100 10 1000000.0
.SAVE v(out)
.END
