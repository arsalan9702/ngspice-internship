Simple RC Transient
Vs in 0 DC 5
R1 in vb 5000
C1 vb 0 100n IC=0
.TRAN 0.5u 2500u UIC
.END
